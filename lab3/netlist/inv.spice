* ============================================================
*  Lab 3 : CMOS Inverter - SKY130 (1.8 V core device)
*
*               vdd
*                |
*            |---+
*   in ---o|   MP  (pfet_01v8, W=wp, L=l)
*            |---+
*                |
*                +------- out
*                |
*            |---+
*   in -----|   MN  (nfet_01v8, W=wn, L=l)
*            |---+
*                |
*               vss
*
*  Sizes are in um (the PDK sets .option scale=1e-6).
* ============================================================
*  ad/as/pd/ps/nrd/nrs: area, perimeter and resistance of the diffusion regions
*  (same formulas as the xschem symbols, 0.29 um = S/D region length).
.subckt inv in out vdd vss params: wn=1 wp=2.5 l=0.15
XMP out in vdd vdd sky130_fd_pr__pfet_01v8 W={wp} L={l}
+ ad={wp*0.29} as={wp*0.29} pd={2*(wp+0.29)} ps={2*(wp+0.29)} nrd={0.29/wp} nrs={0.29/wp}
XMN out in vss vss sky130_fd_pr__nfet_01v8 W={wn} L={l}
+ ad={wn*0.29} as={wn*0.29} pd={2*(wn+0.29)} ps={2*(wn+0.29)} nrd={0.29/wn} nrs={0.29/wn}
.ends inv
