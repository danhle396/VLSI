** sch_path: /cygdrive/d/hoctap/fpga/verilog_school/VLSI/lab3/xschem/inv.sch
.subckt inv in out vdd vss
*.PININFO in:I out:O vdd:B vss:B
XMP out in vdd vdd sky130_fd_pr__pfet_01v8 L=0.15 W=2.5 nf=1 m=1
XMN out in vss vss sky130_fd_pr__nfet_01v8 L=0.15 W=1 nf=1 m=1
.ends
