* NGSPICE file created from inv.ext - technology: sky130A

.subckt inv_post in out vdd vss
X0 out in vdd vdd sky130_fd_pr__pfet_01v8 ad=0.75 pd=5.6 as=0.75 ps=5.6 w=2.5 l=0.15
X1 out in vss vss sky130_fd_pr__nfet_01v8 ad=0.3 pd=2.6 as=0.3 ps=2.6 w=1 l=0.15
C0 vdd in 0.12641f
C1 out vdd 0.15515f
C2 out in 0.06222f
C3 out vss 0.37272f
C4 vdd vss 1.2028f
.ends
