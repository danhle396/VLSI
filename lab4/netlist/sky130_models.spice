* ============================================================
*  Nap model transistor SKY130 (corner TT = typical-typical)
*  Dung thu vien libs.tech/combined (model "continuous", lien tuc theo
*  W/L) - giong xschem. Thu vien libs.tech/ngspice cu la model "micro-binned",
*  chi chinh xac o dung kich thuoc da do dac tinh.
*  Doi duong dan ben duoi neu PDK cai o cho khac.
*  Doi "tt" thanh "ff" / "ss" / "sf" / "fs" de mo phong corner khac.
* ============================================================
.lib "C:/Users/ADMIN/.volare/volare/sky130/versions/c6d73a35f524070e85faff4a6a9eef49553ebc2b/sky130A/libs.tech/combined/sky130.lib.spice" tt
