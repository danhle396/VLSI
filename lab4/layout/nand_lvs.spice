* NGSPICE file created from nand.ext - technology: sky130A

.subckt nand a b y vdd vss
X0 y b vdd vdd sky130_fd_pr__pfet_01v8 ad=0.3875 pd=2.81 as=0.75 ps=5.6 w=2.5 l=0.15
X1 vdd a y vdd sky130_fd_pr__pfet_01v8 ad=0.75 pd=5.6 as=0.3875 ps=2.81 w=2.5 l=0.15
X2 a_170_120# b vss vss sky130_fd_pr__nfet_01v8 ad=0.31 pd=2.31 as=0.6 ps=4.6 w=2 l=0.15
X3 y a a_170_120# vss sky130_fd_pr__nfet_01v8 ad=0.6 pd=4.6 as=0.31 ps=2.31 w=2 l=0.15
.ends
