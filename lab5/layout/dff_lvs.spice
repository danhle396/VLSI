* NGSPICE file created from dff.ext - technology: sky130A

.subckt tgate x y en en_b vdd vss
X0 y en x vss sky130_fd_pr__nfet_01v8 ad=0.57 pd=3.14 as=0.57 ps=3.14 w=1 l=0.15
X1 y en_b x vdd sky130_fd_pr__pfet_01v8 ad=1.425 pd=6.14 as=1.425 ps=6.14 w=2.5 l=0.15
.ends

.subckt inv in out vdd vss
X0 out in vdd vdd sky130_fd_pr__pfet_01v8 ad=0.75 pd=5.6 as=0.75 ps=5.6 w=2.5 l=0.15
X1 out in vss vss sky130_fd_pr__nfet_01v8 ad=0.3 pd=2.6 as=0.3 ps=2.6 w=1 l=0.15
.ends

.subckt dff clk d q qb vdd vss
XXtg1 d m1 clkn clkp vdd vss tgate
XXtg2 m3 m1 clkp clkn vdd vss tgate
XXtg4 s3 s1 clkn clkp vdd vss tgate
XXtg3 m2 s1 clkp clkn vdd vss tgate
XXo1 s3 q vdd vss inv
XXo2 s2 qb vdd vss inv
XXi1 m1 m2 vdd vss inv
XXi2 m2 m3 vdd vss inv
XXi3 s1 s2 vdd vss inv
XXi4 s2 s3 vdd vss inv
XXc1 clk clkn vdd vss inv
XXc2 clkn clkp vdd vss inv
.ends
